// Design: Transistor_Farms/Latched_Shift_Register_360
simulator lang=spectre
global 0
include "/tsmcproject/kits/tsmc/16FF/pdk/models/toplevel.scs" section=top_tt

// tcbn16ffcllbwp16p90cpdlvt/INVD0BWP16P90CPDLVT/schematic
subckt INVD0BWP16P90CPDLVT I ZN VDD VSS VPP VBB
    MM1 (ZN I VSS VBB) nch
    MM0 (ZN I VDD VPP) pch
ends INVD0BWP16P90CPDLVT

// tcbn16ffcllbwp16p90cpdlvt/DFQD0BWP16P90CPDLVT/schematic
subckt DFQD0BWP16P90CPDLVT D CP Q VDD VSS VPP VBB
    MM44 (net103 D VDD VPP) pch
    MM54 (clkb CP VDD VPP) pch
    MM79 (ml_ax clkb net0118 VPP) pch
    MM60 (net0118 ml_b VDD VPP) pch
    MM1 (sl_a clkbb net086 VPP) pch
    MM0 (net086 sl_bx VDD VPP) pch
    MM72 (Q sl_bx VDD VPP) pch
    MDMY004 (net103 clkb net103 VPP) pch
    MM45 (ml_ax clkbb net103 VPP) pch
    MDMY002 (ml_b ml_b ml_b VPP) pch
    MM56 (clkbb clkb VDD VPP) pch
    MM50 (ml_b ml_ax VDD VPP) pch
    MSLTp1 (sl_a clkb ml_b VPP) pch
    MM77 (sl_bx sl_a VDD VPP) pch
    MM47 (net212 D VSS VBB) nch
    MM46 (ml_ax clkb net212 VBB) nch
    MM53 (clkb CP VSS VBB) nch
    MM71 (Q sl_bx VSS VBB) nch
    MDMY003 (net176 net176 net176 VBB) nch
    MDMY005 (net0136 net0136 net0136 VBB) nch
    MM55 (clkbb clkb VSS VBB) nch
    MM64 (ml_ax clkbb net176 VBB) nch
    MM66 (net176 ml_b VSS VBB) nch
    MM49 (ml_b ml_ax VSS VBB) nch
    MM3 (net0136 sl_bx VSS VBB) nch
    MM2 (sl_a clkb net0136 VBB) nch
    MSLTn1 (sl_a clkbb ml_b VBB) nch
    MM76 (sl_bx sl_a VSS VBB) nch
ends DFQD0BWP16P90CPDLVT

// Transistor_Farms/Latched_Shift_Register_20/schematic
subckt Latched_Shift_Register_20 CLK IN Q[0] Q[1] Q[2] Q[3] Q[4] Q[5] Q[6] Q[7] Q[8] Q[9] Q[10] Q[11] Q[12] Q[13] Q[14] Q[15] Q[16] Q[17] Q[18] Q[19] VDD VSS
    I31 (Q[9] CLK Q[10] VDD VSS VDD VSS) DFQD0BWP16P90CPDLVT
    I30 (Q[18] CLK Q[19] VDD VSS VDD VSS) DFQD0BWP16P90CPDLVT
    I21 (Q[8] CLK Q[9] VDD VSS VDD VSS) DFQD0BWP16P90CPDLVT
    I20 (Q[7] CLK Q[8] VDD VSS VDD VSS) DFQD0BWP16P90CPDLVT
    I29 (Q[17] CLK Q[18] VDD VSS VDD VSS) DFQD0BWP16P90CPDLVT
    I28 (Q[13] CLK Q[14] VDD VSS VDD VSS) DFQD0BWP16P90CPDLVT
    I27 (Q[16] CLK Q[17] VDD VSS VDD VSS) DFQD0BWP16P90CPDLVT
    I26 (Q[15] CLK Q[16] VDD VSS VDD VSS) DFQD0BWP16P90CPDLVT
    I11 (Q[3] CLK Q[4] VDD VSS VDD VSS) DFQD0BWP16P90CPDLVT
    I10 (Q[6] CLK Q[7] VDD VSS VDD VSS) DFQD0BWP16P90CPDLVT
    I9 (Q[5] CLK Q[6] VDD VSS VDD VSS) DFQD0BWP16P90CPDLVT
    I8 (Q[4] CLK Q[5] VDD VSS VDD VSS) DFQD0BWP16P90CPDLVT
    I7 (Q[2] CLK Q[3] VDD VSS VDD VSS) DFQD0BWP16P90CPDLVT
    I6 (Q[1] CLK Q[2] VDD VSS VDD VSS) DFQD0BWP16P90CPDLVT
    I5 (Q[0] CLK Q[1] VDD VSS VDD VSS) DFQD0BWP16P90CPDLVT
    I25 (Q[14] CLK Q[15] VDD VSS VDD VSS) DFQD0BWP16P90CPDLVT
    I24 (Q[12] CLK Q[13] VDD VSS VDD VSS) DFQD0BWP16P90CPDLVT
    I23 (Q[11] CLK Q[12] VDD VSS VDD VSS) DFQD0BWP16P90CPDLVT
    I22 (Q[10] CLK Q[11] VDD VSS VDD VSS) DFQD0BWP16P90CPDLVT
    I0 (IN CLK Q[0] VDD VSS VDD VSS) DFQD0BWP16P90CPDLVT
ends Latched_Shift_Register_20

// tcbn16ffcllbwp16p90cpdlvt/CKBD1BWP16P90CPDLVT/schematic
subckt CKBD1BWP16P90CPDLVT I Z VDD VSS VPP VBB
    MM5 (net9 I VSS VBB) nch
    MM0 (Z net9 VSS VBB) nch
    MM4 (net9 I VDD VPP) pch
    MM1 (Z net9 VDD VPP) pch
ends CKBD1BWP16P90CPDLVT

// Transistor_Farms/Latched_Shift_Register_360/schematic
BAR_0 (Q[0] Q_B[0] VDD VSS VDD VSS) INVD0BWP16P90CPDLVT
BAR_1 (Q[1] Q_B[1] VDD VSS VDD VSS) INVD0BWP16P90CPDLVT
BAR_2 (Q[2] Q_B[2] VDD VSS VDD VSS) INVD0BWP16P90CPDLVT
BAR_3 (Q[3] Q_B[3] VDD VSS VDD VSS) INVD0BWP16P90CPDLVT
BAR_4 (Q[4] Q_B[4] VDD VSS VDD VSS) INVD0BWP16P90CPDLVT
BAR_5 (Q[5] Q_B[5] VDD VSS VDD VSS) INVD0BWP16P90CPDLVT
BAR_6 (Q[6] Q_B[6] VDD VSS VDD VSS) INVD0BWP16P90CPDLVT
BAR_7 (Q[7] Q_B[7] VDD VSS VDD VSS) INVD0BWP16P90CPDLVT
BAR_8 (Q[8] Q_B[8] VDD VSS VDD VSS) INVD0BWP16P90CPDLVT
BAR_9 (Q[9] Q_B[9] VDD VSS VDD VSS) INVD0BWP16P90CPDLVT
BAR_10 (Q[10] Q_B[10] VDD VSS VDD VSS) INVD0BWP16P90CPDLVT
BAR_11 (Q[11] Q_B[11] VDD VSS VDD VSS) INVD0BWP16P90CPDLVT
BAR_12 (Q[12] Q_B[12] VDD VSS VDD VSS) INVD0BWP16P90CPDLVT
BAR_13 (Q[13] Q_B[13] VDD VSS VDD VSS) INVD0BWP16P90CPDLVT
BAR_14 (Q[14] Q_B[14] VDD VSS VDD VSS) INVD0BWP16P90CPDLVT
BAR_15 (Q[15] Q_B[15] VDD VSS VDD VSS) INVD0BWP16P90CPDLVT
BAR_16 (Q[16] Q_B[16] VDD VSS VDD VSS) INVD0BWP16P90CPDLVT
BAR_17 (Q[17] Q_B[17] VDD VSS VDD VSS) INVD0BWP16P90CPDLVT
BAR_18 (Q[18] Q_B[18] VDD VSS VDD VSS) INVD0BWP16P90CPDLVT
BAR_19 (Q[19] Q_B[19] VDD VSS VDD VSS) INVD0BWP16P90CPDLVT
BAR_20 (Q[20] Q_B[20] VDD VSS VDD VSS) INVD0BWP16P90CPDLVT
BAR_21 (Q[21] Q_B[21] VDD VSS VDD VSS) INVD0BWP16P90CPDLVT
BAR_22 (Q[22] Q_B[22] VDD VSS VDD VSS) INVD0BWP16P90CPDLVT
BAR_23 (Q[23] Q_B[23] VDD VSS VDD VSS) INVD0BWP16P90CPDLVT
BAR_24 (Q[24] Q_B[24] VDD VSS VDD VSS) INVD0BWP16P90CPDLVT
BAR_25 (Q[25] Q_B[25] VDD VSS VDD VSS) INVD0BWP16P90CPDLVT
BAR_26 (Q[26] Q_B[26] VDD VSS VDD VSS) INVD0BWP16P90CPDLVT
BAR_27 (Q[27] Q_B[27] VDD VSS VDD VSS) INVD0BWP16P90CPDLVT
BAR_28 (Q[28] Q_B[28] VDD VSS VDD VSS) INVD0BWP16P90CPDLVT
BAR_29 (Q[29] Q_B[29] VDD VSS VDD VSS) INVD0BWP16P90CPDLVT
BAR_30 (Q[30] Q_B[30] VDD VSS VDD VSS) INVD0BWP16P90CPDLVT
BAR_31 (Q[31] Q_B[31] VDD VSS VDD VSS) INVD0BWP16P90CPDLVT
BAR_32 (Q[32] Q_B[32] VDD VSS VDD VSS) INVD0BWP16P90CPDLVT
BAR_33 (Q[33] Q_B[33] VDD VSS VDD VSS) INVD0BWP16P90CPDLVT
BAR_34 (Q[34] Q_B[34] VDD VSS VDD VSS) INVD0BWP16P90CPDLVT
BAR_35 (Q[35] Q_B[35] VDD VSS VDD VSS) INVD0BWP16P90CPDLVT
BAR_36 (Q[36] Q_B[36] VDD VSS VDD VSS) INVD0BWP16P90CPDLVT
BAR_37 (Q[37] Q_B[37] VDD VSS VDD VSS) INVD0BWP16P90CPDLVT
BAR_38 (Q[38] Q_B[38] VDD VSS VDD VSS) INVD0BWP16P90CPDLVT
BAR_39 (Q[39] Q_B[39] VDD VSS VDD VSS) INVD0BWP16P90CPDLVT
BAR_40 (Q[40] Q_B[40] VDD VSS VDD VSS) INVD0BWP16P90CPDLVT
BAR_41 (Q[41] Q_B[41] VDD VSS VDD VSS) INVD0BWP16P90CPDLVT
BAR_42 (Q[42] Q_B[42] VDD VSS VDD VSS) INVD0BWP16P90CPDLVT
BAR_43 (Q[43] Q_B[43] VDD VSS VDD VSS) INVD0BWP16P90CPDLVT
BAR_44 (Q[44] Q_B[44] VDD VSS VDD VSS) INVD0BWP16P90CPDLVT
BAR_45 (Q[45] Q_B[45] VDD VSS VDD VSS) INVD0BWP16P90CPDLVT
BAR_46 (Q[46] Q_B[46] VDD VSS VDD VSS) INVD0BWP16P90CPDLVT
BAR_47 (Q[47] Q_B[47] VDD VSS VDD VSS) INVD0BWP16P90CPDLVT
BAR_48 (Q[48] Q_B[48] VDD VSS VDD VSS) INVD0BWP16P90CPDLVT
BAR_49 (Q[49] Q_B[49] VDD VSS VDD VSS) INVD0BWP16P90CPDLVT
BAR_50 (Q[50] Q_B[50] VDD VSS VDD VSS) INVD0BWP16P90CPDLVT
BAR_51 (Q[51] Q_B[51] VDD VSS VDD VSS) INVD0BWP16P90CPDLVT
BAR_52 (Q[52] Q_B[52] VDD VSS VDD VSS) INVD0BWP16P90CPDLVT
BAR_53 (Q[53] Q_B[53] VDD VSS VDD VSS) INVD0BWP16P90CPDLVT
BAR_54 (Q[54] Q_B[54] VDD VSS VDD VSS) INVD0BWP16P90CPDLVT
BAR_55 (Q[55] Q_B[55] VDD VSS VDD VSS) INVD0BWP16P90CPDLVT
BAR_56 (Q[56] Q_B[56] VDD VSS VDD VSS) INVD0BWP16P90CPDLVT
BAR_57 (Q[57] Q_B[57] VDD VSS VDD VSS) INVD0BWP16P90CPDLVT
BAR_58 (Q[58] Q_B[58] VDD VSS VDD VSS) INVD0BWP16P90CPDLVT
BAR_59 (Q[59] Q_B[59] VDD VSS VDD VSS) INVD0BWP16P90CPDLVT
BAR_60 (Q[60] Q_B[60] VDD VSS VDD VSS) INVD0BWP16P90CPDLVT
BAR_61 (Q[61] Q_B[61] VDD VSS VDD VSS) INVD0BWP16P90CPDLVT
BAR_62 (Q[62] Q_B[62] VDD VSS VDD VSS) INVD0BWP16P90CPDLVT
BAR_63 (Q[63] Q_B[63] VDD VSS VDD VSS) INVD0BWP16P90CPDLVT
BAR_64 (Q[64] Q_B[64] VDD VSS VDD VSS) INVD0BWP16P90CPDLVT
BAR_65 (Q[65] Q_B[65] VDD VSS VDD VSS) INVD0BWP16P90CPDLVT
BAR_66 (Q[66] Q_B[66] VDD VSS VDD VSS) INVD0BWP16P90CPDLVT
BAR_67 (Q[67] Q_B[67] VDD VSS VDD VSS) INVD0BWP16P90CPDLVT
BAR_68 (Q[68] Q_B[68] VDD VSS VDD VSS) INVD0BWP16P90CPDLVT
BAR_69 (Q[69] Q_B[69] VDD VSS VDD VSS) INVD0BWP16P90CPDLVT
BAR_70 (Q[70] Q_B[70] VDD VSS VDD VSS) INVD0BWP16P90CPDLVT
BAR_71 (Q[71] Q_B[71] VDD VSS VDD VSS) INVD0BWP16P90CPDLVT
BAR_72 (Q[72] Q_B[72] VDD VSS VDD VSS) INVD0BWP16P90CPDLVT
BAR_73 (Q[73] Q_B[73] VDD VSS VDD VSS) INVD0BWP16P90CPDLVT
BAR_74 (Q[74] Q_B[74] VDD VSS VDD VSS) INVD0BWP16P90CPDLVT
BAR_75 (Q[75] Q_B[75] VDD VSS VDD VSS) INVD0BWP16P90CPDLVT
BAR_76 (Q[76] Q_B[76] VDD VSS VDD VSS) INVD0BWP16P90CPDLVT
BAR_77 (Q[77] Q_B[77] VDD VSS VDD VSS) INVD0BWP16P90CPDLVT
BAR_78 (Q[78] Q_B[78] VDD VSS VDD VSS) INVD0BWP16P90CPDLVT
BAR_79 (Q[79] Q_B[79] VDD VSS VDD VSS) INVD0BWP16P90CPDLVT
BAR_80 (Q[80] Q_B[80] VDD VSS VDD VSS) INVD0BWP16P90CPDLVT
BAR_81 (Q[81] Q_B[81] VDD VSS VDD VSS) INVD0BWP16P90CPDLVT
BAR_82 (Q[82] Q_B[82] VDD VSS VDD VSS) INVD0BWP16P90CPDLVT
BAR_83 (Q[83] Q_B[83] VDD VSS VDD VSS) INVD0BWP16P90CPDLVT
BAR_84 (Q[84] Q_B[84] VDD VSS VDD VSS) INVD0BWP16P90CPDLVT
BAR_85 (Q[85] Q_B[85] VDD VSS VDD VSS) INVD0BWP16P90CPDLVT
BAR_86 (Q[86] Q_B[86] VDD VSS VDD VSS) INVD0BWP16P90CPDLVT
BAR_87 (Q[87] Q_B[87] VDD VSS VDD VSS) INVD0BWP16P90CPDLVT
BAR_88 (Q[88] Q_B[88] VDD VSS VDD VSS) INVD0BWP16P90CPDLVT
BAR_89 (Q[89] Q_B[89] VDD VSS VDD VSS) INVD0BWP16P90CPDLVT
BAR_90 (Q[90] Q_B[90] VDD VSS VDD VSS) INVD0BWP16P90CPDLVT
BAR_91 (Q[91] Q_B[91] VDD VSS VDD VSS) INVD0BWP16P90CPDLVT
BAR_92 (Q[92] Q_B[92] VDD VSS VDD VSS) INVD0BWP16P90CPDLVT
BAR_93 (Q[93] Q_B[93] VDD VSS VDD VSS) INVD0BWP16P90CPDLVT
BAR_94 (Q[94] Q_B[94] VDD VSS VDD VSS) INVD0BWP16P90CPDLVT
BAR_95 (Q[95] Q_B[95] VDD VSS VDD VSS) INVD0BWP16P90CPDLVT
BAR_96 (Q[96] Q_B[96] VDD VSS VDD VSS) INVD0BWP16P90CPDLVT
BAR_97 (Q[97] Q_B[97] VDD VSS VDD VSS) INVD0BWP16P90CPDLVT
BAR_98 (Q[98] Q_B[98] VDD VSS VDD VSS) INVD0BWP16P90CPDLVT
BAR_99 (Q[99] Q_B[99] VDD VSS VDD VSS) INVD0BWP16P90CPDLVT
BAR_100 (Q[100] Q_B[100] VDD VSS VDD VSS) INVD0BWP16P90CPDLVT
BAR_101 (Q[101] Q_B[101] VDD VSS VDD VSS) INVD0BWP16P90CPDLVT
BAR_102 (Q[102] Q_B[102] VDD VSS VDD VSS) INVD0BWP16P90CPDLVT
BAR_103 (Q[103] Q_B[103] VDD VSS VDD VSS) INVD0BWP16P90CPDLVT
BAR_104 (Q[104] Q_B[104] VDD VSS VDD VSS) INVD0BWP16P90CPDLVT
BAR_105 (Q[105] Q_B[105] VDD VSS VDD VSS) INVD0BWP16P90CPDLVT
BAR_106 (Q[106] Q_B[106] VDD VSS VDD VSS) INVD0BWP16P90CPDLVT
BAR_107 (Q[107] Q_B[107] VDD VSS VDD VSS) INVD0BWP16P90CPDLVT
BAR_108 (Q[108] Q_B[108] VDD VSS VDD VSS) INVD0BWP16P90CPDLVT
BAR_109 (Q[109] Q_B[109] VDD VSS VDD VSS) INVD0BWP16P90CPDLVT
BAR_110 (Q[110] Q_B[110] VDD VSS VDD VSS) INVD0BWP16P90CPDLVT
BAR_111 (Q[111] Q_B[111] VDD VSS VDD VSS) INVD0BWP16P90CPDLVT
BAR_112 (Q[112] Q_B[112] VDD VSS VDD VSS) INVD0BWP16P90CPDLVT
BAR_113 (Q[113] Q_B[113] VDD VSS VDD VSS) INVD0BWP16P90CPDLVT
BAR_114 (Q[114] Q_B[114] VDD VSS VDD VSS) INVD0BWP16P90CPDLVT
BAR_115 (Q[115] Q_B[115] VDD VSS VDD VSS) INVD0BWP16P90CPDLVT
BAR_116 (Q[116] Q_B[116] VDD VSS VDD VSS) INVD0BWP16P90CPDLVT
BAR_117 (Q[117] Q_B[117] VDD VSS VDD VSS) INVD0BWP16P90CPDLVT
BAR_118 (Q[118] Q_B[118] VDD VSS VDD VSS) INVD0BWP16P90CPDLVT
BAR_119 (Q[119] Q_B[119] VDD VSS VDD VSS) INVD0BWP16P90CPDLVT
BAR_120 (Q[120] Q_B[120] VDD VSS VDD VSS) INVD0BWP16P90CPDLVT
BAR_121 (Q[121] Q_B[121] VDD VSS VDD VSS) INVD0BWP16P90CPDLVT
BAR_122 (Q[122] Q_B[122] VDD VSS VDD VSS) INVD0BWP16P90CPDLVT
BAR_123 (Q[123] Q_B[123] VDD VSS VDD VSS) INVD0BWP16P90CPDLVT
BAR_124 (Q[124] Q_B[124] VDD VSS VDD VSS) INVD0BWP16P90CPDLVT
BAR_125 (Q[125] Q_B[125] VDD VSS VDD VSS) INVD0BWP16P90CPDLVT
BAR_126 (Q[126] Q_B[126] VDD VSS VDD VSS) INVD0BWP16P90CPDLVT
BAR_127 (Q[127] Q_B[127] VDD VSS VDD VSS) INVD0BWP16P90CPDLVT
BAR_128 (Q[128] Q_B[128] VDD VSS VDD VSS) INVD0BWP16P90CPDLVT
BAR_129 (Q[129] Q_B[129] VDD VSS VDD VSS) INVD0BWP16P90CPDLVT
BAR_130 (Q[130] Q_B[130] VDD VSS VDD VSS) INVD0BWP16P90CPDLVT
BAR_131 (Q[131] Q_B[131] VDD VSS VDD VSS) INVD0BWP16P90CPDLVT
BAR_132 (Q[132] Q_B[132] VDD VSS VDD VSS) INVD0BWP16P90CPDLVT
BAR_133 (Q[133] Q_B[133] VDD VSS VDD VSS) INVD0BWP16P90CPDLVT
BAR_134 (Q[134] Q_B[134] VDD VSS VDD VSS) INVD0BWP16P90CPDLVT
BAR_135 (Q[135] Q_B[135] VDD VSS VDD VSS) INVD0BWP16P90CPDLVT
BAR_136 (Q[136] Q_B[136] VDD VSS VDD VSS) INVD0BWP16P90CPDLVT
BAR_137 (Q[137] Q_B[137] VDD VSS VDD VSS) INVD0BWP16P90CPDLVT
BAR_138 (Q[138] Q_B[138] VDD VSS VDD VSS) INVD0BWP16P90CPDLVT
BAR_139 (Q[139] Q_B[139] VDD VSS VDD VSS) INVD0BWP16P90CPDLVT
BAR_140 (Q[140] Q_B[140] VDD VSS VDD VSS) INVD0BWP16P90CPDLVT
BAR_141 (Q[141] Q_B[141] VDD VSS VDD VSS) INVD0BWP16P90CPDLVT
BAR_142 (Q[142] Q_B[142] VDD VSS VDD VSS) INVD0BWP16P90CPDLVT
BAR_143 (Q[143] Q_B[143] VDD VSS VDD VSS) INVD0BWP16P90CPDLVT
BAR_144 (Q[144] Q_B[144] VDD VSS VDD VSS) INVD0BWP16P90CPDLVT
BAR_145 (Q[145] Q_B[145] VDD VSS VDD VSS) INVD0BWP16P90CPDLVT
BAR_146 (Q[146] Q_B[146] VDD VSS VDD VSS) INVD0BWP16P90CPDLVT
BAR_147 (Q[147] Q_B[147] VDD VSS VDD VSS) INVD0BWP16P90CPDLVT
BAR_148 (Q[148] Q_B[148] VDD VSS VDD VSS) INVD0BWP16P90CPDLVT
BAR_149 (Q[149] Q_B[149] VDD VSS VDD VSS) INVD0BWP16P90CPDLVT
BAR_150 (Q[150] Q_B[150] VDD VSS VDD VSS) INVD0BWP16P90CPDLVT
BAR_151 (Q[151] Q_B[151] VDD VSS VDD VSS) INVD0BWP16P90CPDLVT
BAR_152 (Q[152] Q_B[152] VDD VSS VDD VSS) INVD0BWP16P90CPDLVT
BAR_153 (Q[153] Q_B[153] VDD VSS VDD VSS) INVD0BWP16P90CPDLVT
BAR_154 (Q[154] Q_B[154] VDD VSS VDD VSS) INVD0BWP16P90CPDLVT
BAR_155 (Q[155] Q_B[155] VDD VSS VDD VSS) INVD0BWP16P90CPDLVT
BAR_156 (Q[156] Q_B[156] VDD VSS VDD VSS) INVD0BWP16P90CPDLVT
BAR_157 (Q[157] Q_B[157] VDD VSS VDD VSS) INVD0BWP16P90CPDLVT
BAR_158 (Q[158] Q_B[158] VDD VSS VDD VSS) INVD0BWP16P90CPDLVT
BAR_159 (Q[159] Q_B[159] VDD VSS VDD VSS) INVD0BWP16P90CPDLVT
BAR_160 (Q[160] Q_B[160] VDD VSS VDD VSS) INVD0BWP16P90CPDLVT
BAR_161 (Q[161] Q_B[161] VDD VSS VDD VSS) INVD0BWP16P90CPDLVT
BAR_162 (Q[162] Q_B[162] VDD VSS VDD VSS) INVD0BWP16P90CPDLVT
BAR_163 (Q[163] Q_B[163] VDD VSS VDD VSS) INVD0BWP16P90CPDLVT
BAR_164 (Q[164] Q_B[164] VDD VSS VDD VSS) INVD0BWP16P90CPDLVT
BAR_165 (Q[165] Q_B[165] VDD VSS VDD VSS) INVD0BWP16P90CPDLVT
BAR_166 (Q[166] Q_B[166] VDD VSS VDD VSS) INVD0BWP16P90CPDLVT
BAR_167 (Q[167] Q_B[167] VDD VSS VDD VSS) INVD0BWP16P90CPDLVT
BAR_168 (Q[168] Q_B[168] VDD VSS VDD VSS) INVD0BWP16P90CPDLVT
BAR_169 (Q[169] Q_B[169] VDD VSS VDD VSS) INVD0BWP16P90CPDLVT
BAR_170 (Q[170] Q_B[170] VDD VSS VDD VSS) INVD0BWP16P90CPDLVT
BAR_171 (Q[171] Q_B[171] VDD VSS VDD VSS) INVD0BWP16P90CPDLVT
BAR_172 (Q[172] Q_B[172] VDD VSS VDD VSS) INVD0BWP16P90CPDLVT
BAR_173 (Q[173] Q_B[173] VDD VSS VDD VSS) INVD0BWP16P90CPDLVT
BAR_174 (Q[174] Q_B[174] VDD VSS VDD VSS) INVD0BWP16P90CPDLVT
BAR_175 (Q[175] Q_B[175] VDD VSS VDD VSS) INVD0BWP16P90CPDLVT
BAR_176 (Q[176] Q_B[176] VDD VSS VDD VSS) INVD0BWP16P90CPDLVT
BAR_177 (Q[177] Q_B[177] VDD VSS VDD VSS) INVD0BWP16P90CPDLVT
BAR_178 (Q[178] Q_B[178] VDD VSS VDD VSS) INVD0BWP16P90CPDLVT
BAR_179 (Q[179] Q_B[179] VDD VSS VDD VSS) INVD0BWP16P90CPDLVT
BAR_180 (Q[180] Q_B[180] VDD VSS VDD VSS) INVD0BWP16P90CPDLVT
BAR_181 (Q[181] Q_B[181] VDD VSS VDD VSS) INVD0BWP16P90CPDLVT
BAR_182 (Q[182] Q_B[182] VDD VSS VDD VSS) INVD0BWP16P90CPDLVT
BAR_183 (Q[183] Q_B[183] VDD VSS VDD VSS) INVD0BWP16P90CPDLVT
BAR_184 (Q[184] Q_B[184] VDD VSS VDD VSS) INVD0BWP16P90CPDLVT
BAR_185 (Q[185] Q_B[185] VDD VSS VDD VSS) INVD0BWP16P90CPDLVT
BAR_186 (Q[186] Q_B[186] VDD VSS VDD VSS) INVD0BWP16P90CPDLVT
BAR_187 (Q[187] Q_B[187] VDD VSS VDD VSS) INVD0BWP16P90CPDLVT
BAR_188 (Q[188] Q_B[188] VDD VSS VDD VSS) INVD0BWP16P90CPDLVT
BAR_189 (Q[189] Q_B[189] VDD VSS VDD VSS) INVD0BWP16P90CPDLVT
BAR_190 (Q[190] Q_B[190] VDD VSS VDD VSS) INVD0BWP16P90CPDLVT
BAR_191 (Q[191] Q_B[191] VDD VSS VDD VSS) INVD0BWP16P90CPDLVT
BAR_192 (Q[192] Q_B[192] VDD VSS VDD VSS) INVD0BWP16P90CPDLVT
BAR_193 (Q[193] Q_B[193] VDD VSS VDD VSS) INVD0BWP16P90CPDLVT
BAR_194 (Q[194] Q_B[194] VDD VSS VDD VSS) INVD0BWP16P90CPDLVT
BAR_195 (Q[195] Q_B[195] VDD VSS VDD VSS) INVD0BWP16P90CPDLVT
BAR_196 (Q[196] Q_B[196] VDD VSS VDD VSS) INVD0BWP16P90CPDLVT
BAR_197 (Q[197] Q_B[197] VDD VSS VDD VSS) INVD0BWP16P90CPDLVT
BAR_198 (Q[198] Q_B[198] VDD VSS VDD VSS) INVD0BWP16P90CPDLVT
BAR_199 (Q[199] Q_B[199] VDD VSS VDD VSS) INVD0BWP16P90CPDLVT
BAR_200 (Q[200] Q_B[200] VDD VSS VDD VSS) INVD0BWP16P90CPDLVT
BAR_201 (Q[201] Q_B[201] VDD VSS VDD VSS) INVD0BWP16P90CPDLVT
BAR_202 (Q[202] Q_B[202] VDD VSS VDD VSS) INVD0BWP16P90CPDLVT
BAR_203 (Q[203] Q_B[203] VDD VSS VDD VSS) INVD0BWP16P90CPDLVT
BAR_204 (Q[204] Q_B[204] VDD VSS VDD VSS) INVD0BWP16P90CPDLVT
BAR_205 (Q[205] Q_B[205] VDD VSS VDD VSS) INVD0BWP16P90CPDLVT
BAR_206 (Q[206] Q_B[206] VDD VSS VDD VSS) INVD0BWP16P90CPDLVT
BAR_207 (Q[207] Q_B[207] VDD VSS VDD VSS) INVD0BWP16P90CPDLVT
BAR_208 (Q[208] Q_B[208] VDD VSS VDD VSS) INVD0BWP16P90CPDLVT
BAR_209 (Q[209] Q_B[209] VDD VSS VDD VSS) INVD0BWP16P90CPDLVT
BAR_210 (Q[210] Q_B[210] VDD VSS VDD VSS) INVD0BWP16P90CPDLVT
BAR_211 (Q[211] Q_B[211] VDD VSS VDD VSS) INVD0BWP16P90CPDLVT
BAR_212 (Q[212] Q_B[212] VDD VSS VDD VSS) INVD0BWP16P90CPDLVT
BAR_213 (Q[213] Q_B[213] VDD VSS VDD VSS) INVD0BWP16P90CPDLVT
BAR_214 (Q[214] Q_B[214] VDD VSS VDD VSS) INVD0BWP16P90CPDLVT
BAR_215 (Q[215] Q_B[215] VDD VSS VDD VSS) INVD0BWP16P90CPDLVT
BAR_216 (Q[216] Q_B[216] VDD VSS VDD VSS) INVD0BWP16P90CPDLVT
BAR_217 (Q[217] Q_B[217] VDD VSS VDD VSS) INVD0BWP16P90CPDLVT
BAR_218 (Q[218] Q_B[218] VDD VSS VDD VSS) INVD0BWP16P90CPDLVT
BAR_219 (Q[219] Q_B[219] VDD VSS VDD VSS) INVD0BWP16P90CPDLVT
BAR_220 (Q[220] Q_B[220] VDD VSS VDD VSS) INVD0BWP16P90CPDLVT
BAR_221 (Q[221] Q_B[221] VDD VSS VDD VSS) INVD0BWP16P90CPDLVT
BAR_222 (Q[222] Q_B[222] VDD VSS VDD VSS) INVD0BWP16P90CPDLVT
BAR_223 (Q[223] Q_B[223] VDD VSS VDD VSS) INVD0BWP16P90CPDLVT
BAR_224 (Q[224] Q_B[224] VDD VSS VDD VSS) INVD0BWP16P90CPDLVT
BAR_225 (Q[225] Q_B[225] VDD VSS VDD VSS) INVD0BWP16P90CPDLVT
BAR_226 (Q[226] Q_B[226] VDD VSS VDD VSS) INVD0BWP16P90CPDLVT
BAR_227 (Q[227] Q_B[227] VDD VSS VDD VSS) INVD0BWP16P90CPDLVT
BAR_228 (Q[228] Q_B[228] VDD VSS VDD VSS) INVD0BWP16P90CPDLVT
BAR_229 (Q[229] Q_B[229] VDD VSS VDD VSS) INVD0BWP16P90CPDLVT
BAR_230 (Q[230] Q_B[230] VDD VSS VDD VSS) INVD0BWP16P90CPDLVT
BAR_231 (Q[231] Q_B[231] VDD VSS VDD VSS) INVD0BWP16P90CPDLVT
BAR_232 (Q[232] Q_B[232] VDD VSS VDD VSS) INVD0BWP16P90CPDLVT
BAR_233 (Q[233] Q_B[233] VDD VSS VDD VSS) INVD0BWP16P90CPDLVT
BAR_234 (Q[234] Q_B[234] VDD VSS VDD VSS) INVD0BWP16P90CPDLVT
BAR_235 (Q[235] Q_B[235] VDD VSS VDD VSS) INVD0BWP16P90CPDLVT
BAR_236 (Q[236] Q_B[236] VDD VSS VDD VSS) INVD0BWP16P90CPDLVT
BAR_237 (Q[237] Q_B[237] VDD VSS VDD VSS) INVD0BWP16P90CPDLVT
BAR_238 (Q[238] Q_B[238] VDD VSS VDD VSS) INVD0BWP16P90CPDLVT
BAR_239 (Q[239] Q_B[239] VDD VSS VDD VSS) INVD0BWP16P90CPDLVT
BAR_240 (Q[240] Q_B[240] VDD VSS VDD VSS) INVD0BWP16P90CPDLVT
BAR_241 (Q[241] Q_B[241] VDD VSS VDD VSS) INVD0BWP16P90CPDLVT
BAR_242 (Q[242] Q_B[242] VDD VSS VDD VSS) INVD0BWP16P90CPDLVT
BAR_243 (Q[243] Q_B[243] VDD VSS VDD VSS) INVD0BWP16P90CPDLVT
BAR_244 (Q[244] Q_B[244] VDD VSS VDD VSS) INVD0BWP16P90CPDLVT
BAR_245 (Q[245] Q_B[245] VDD VSS VDD VSS) INVD0BWP16P90CPDLVT
BAR_246 (Q[246] Q_B[246] VDD VSS VDD VSS) INVD0BWP16P90CPDLVT
BAR_247 (Q[247] Q_B[247] VDD VSS VDD VSS) INVD0BWP16P90CPDLVT
BAR_248 (Q[248] Q_B[248] VDD VSS VDD VSS) INVD0BWP16P90CPDLVT
BAR_249 (Q[249] Q_B[249] VDD VSS VDD VSS) INVD0BWP16P90CPDLVT
BAR_250 (Q[250] Q_B[250] VDD VSS VDD VSS) INVD0BWP16P90CPDLVT
BAR_251 (Q[251] Q_B[251] VDD VSS VDD VSS) INVD0BWP16P90CPDLVT
BAR_252 (Q[252] Q_B[252] VDD VSS VDD VSS) INVD0BWP16P90CPDLVT
BAR_253 (Q[253] Q_B[253] VDD VSS VDD VSS) INVD0BWP16P90CPDLVT
BAR_254 (Q[254] Q_B[254] VDD VSS VDD VSS) INVD0BWP16P90CPDLVT
BAR_255 (Q[255] Q_B[255] VDD VSS VDD VSS) INVD0BWP16P90CPDLVT
BAR_256 (Q[256] Q_B[256] VDD VSS VDD VSS) INVD0BWP16P90CPDLVT
BAR_257 (Q[257] Q_B[257] VDD VSS VDD VSS) INVD0BWP16P90CPDLVT
BAR_258 (Q[258] Q_B[258] VDD VSS VDD VSS) INVD0BWP16P90CPDLVT
BAR_259 (Q[259] Q_B[259] VDD VSS VDD VSS) INVD0BWP16P90CPDLVT
BAR_260 (Q[260] Q_B[260] VDD VSS VDD VSS) INVD0BWP16P90CPDLVT
BAR_261 (Q[261] Q_B[261] VDD VSS VDD VSS) INVD0BWP16P90CPDLVT
BAR_262 (Q[262] Q_B[262] VDD VSS VDD VSS) INVD0BWP16P90CPDLVT
BAR_263 (Q[263] Q_B[263] VDD VSS VDD VSS) INVD0BWP16P90CPDLVT
BAR_264 (Q[264] Q_B[264] VDD VSS VDD VSS) INVD0BWP16P90CPDLVT
BAR_265 (Q[265] Q_B[265] VDD VSS VDD VSS) INVD0BWP16P90CPDLVT
BAR_266 (Q[266] Q_B[266] VDD VSS VDD VSS) INVD0BWP16P90CPDLVT
BAR_267 (Q[267] Q_B[267] VDD VSS VDD VSS) INVD0BWP16P90CPDLVT
BAR_268 (Q[268] Q_B[268] VDD VSS VDD VSS) INVD0BWP16P90CPDLVT
BAR_269 (Q[269] Q_B[269] VDD VSS VDD VSS) INVD0BWP16P90CPDLVT
BAR_270 (Q[270] Q_B[270] VDD VSS VDD VSS) INVD0BWP16P90CPDLVT
BAR_271 (Q[271] Q_B[271] VDD VSS VDD VSS) INVD0BWP16P90CPDLVT
BAR_272 (Q[272] Q_B[272] VDD VSS VDD VSS) INVD0BWP16P90CPDLVT
BAR_273 (Q[273] Q_B[273] VDD VSS VDD VSS) INVD0BWP16P90CPDLVT
BAR_274 (Q[274] Q_B[274] VDD VSS VDD VSS) INVD0BWP16P90CPDLVT
BAR_275 (Q[275] Q_B[275] VDD VSS VDD VSS) INVD0BWP16P90CPDLVT
BAR_276 (Q[276] Q_B[276] VDD VSS VDD VSS) INVD0BWP16P90CPDLVT
BAR_277 (Q[277] Q_B[277] VDD VSS VDD VSS) INVD0BWP16P90CPDLVT
BAR_278 (Q[278] Q_B[278] VDD VSS VDD VSS) INVD0BWP16P90CPDLVT
BAR_279 (Q[279] Q_B[279] VDD VSS VDD VSS) INVD0BWP16P90CPDLVT
BAR_280 (Q[280] Q_B[280] VDD VSS VDD VSS) INVD0BWP16P90CPDLVT
BAR_281 (Q[281] Q_B[281] VDD VSS VDD VSS) INVD0BWP16P90CPDLVT
BAR_282 (Q[282] Q_B[282] VDD VSS VDD VSS) INVD0BWP16P90CPDLVT
BAR_283 (Q[283] Q_B[283] VDD VSS VDD VSS) INVD0BWP16P90CPDLVT
BAR_284 (Q[284] Q_B[284] VDD VSS VDD VSS) INVD0BWP16P90CPDLVT
BAR_285 (Q[285] Q_B[285] VDD VSS VDD VSS) INVD0BWP16P90CPDLVT
BAR_286 (Q[286] Q_B[286] VDD VSS VDD VSS) INVD0BWP16P90CPDLVT
BAR_287 (Q[287] Q_B[287] VDD VSS VDD VSS) INVD0BWP16P90CPDLVT
BAR_288 (Q[288] Q_B[288] VDD VSS VDD VSS) INVD0BWP16P90CPDLVT
BAR_289 (Q[289] Q_B[289] VDD VSS VDD VSS) INVD0BWP16P90CPDLVT
BAR_290 (Q[290] Q_B[290] VDD VSS VDD VSS) INVD0BWP16P90CPDLVT
BAR_291 (Q[291] Q_B[291] VDD VSS VDD VSS) INVD0BWP16P90CPDLVT
BAR_292 (Q[292] Q_B[292] VDD VSS VDD VSS) INVD0BWP16P90CPDLVT
BAR_293 (Q[293] Q_B[293] VDD VSS VDD VSS) INVD0BWP16P90CPDLVT
BAR_294 (Q[294] Q_B[294] VDD VSS VDD VSS) INVD0BWP16P90CPDLVT
BAR_295 (Q[295] Q_B[295] VDD VSS VDD VSS) INVD0BWP16P90CPDLVT
BAR_296 (Q[296] Q_B[296] VDD VSS VDD VSS) INVD0BWP16P90CPDLVT
BAR_297 (Q[297] Q_B[297] VDD VSS VDD VSS) INVD0BWP16P90CPDLVT
BAR_298 (Q[298] Q_B[298] VDD VSS VDD VSS) INVD0BWP16P90CPDLVT
BAR_299 (Q[299] Q_B[299] VDD VSS VDD VSS) INVD0BWP16P90CPDLVT
BAR_300 (Q[300] Q_B[300] VDD VSS VDD VSS) INVD0BWP16P90CPDLVT
BAR_301 (Q[301] Q_B[301] VDD VSS VDD VSS) INVD0BWP16P90CPDLVT
BAR_302 (Q[302] Q_B[302] VDD VSS VDD VSS) INVD0BWP16P90CPDLVT
BAR_303 (Q[303] Q_B[303] VDD VSS VDD VSS) INVD0BWP16P90CPDLVT
BAR_304 (Q[304] Q_B[304] VDD VSS VDD VSS) INVD0BWP16P90CPDLVT
BAR_305 (Q[305] Q_B[305] VDD VSS VDD VSS) INVD0BWP16P90CPDLVT
BAR_306 (Q[306] Q_B[306] VDD VSS VDD VSS) INVD0BWP16P90CPDLVT
BAR_307 (Q[307] Q_B[307] VDD VSS VDD VSS) INVD0BWP16P90CPDLVT
BAR_308 (Q[308] Q_B[308] VDD VSS VDD VSS) INVD0BWP16P90CPDLVT
BAR_309 (Q[309] Q_B[309] VDD VSS VDD VSS) INVD0BWP16P90CPDLVT
BAR_310 (Q[310] Q_B[310] VDD VSS VDD VSS) INVD0BWP16P90CPDLVT
BAR_311 (Q[311] Q_B[311] VDD VSS VDD VSS) INVD0BWP16P90CPDLVT
BAR_312 (Q[312] Q_B[312] VDD VSS VDD VSS) INVD0BWP16P90CPDLVT
BAR_313 (Q[313] Q_B[313] VDD VSS VDD VSS) INVD0BWP16P90CPDLVT
BAR_314 (Q[314] Q_B[314] VDD VSS VDD VSS) INVD0BWP16P90CPDLVT
BAR_315 (Q[315] Q_B[315] VDD VSS VDD VSS) INVD0BWP16P90CPDLVT
BAR_316 (Q[316] Q_B[316] VDD VSS VDD VSS) INVD0BWP16P90CPDLVT
BAR_317 (Q[317] Q_B[317] VDD VSS VDD VSS) INVD0BWP16P90CPDLVT
BAR_318 (Q[318] Q_B[318] VDD VSS VDD VSS) INVD0BWP16P90CPDLVT
BAR_319 (Q[319] Q_B[319] VDD VSS VDD VSS) INVD0BWP16P90CPDLVT
BAR_320 (Q[320] Q_B[320] VDD VSS VDD VSS) INVD0BWP16P90CPDLVT
BAR_321 (Q[321] Q_B[321] VDD VSS VDD VSS) INVD0BWP16P90CPDLVT
BAR_322 (Q[322] Q_B[322] VDD VSS VDD VSS) INVD0BWP16P90CPDLVT
BAR_323 (Q[323] Q_B[323] VDD VSS VDD VSS) INVD0BWP16P90CPDLVT
BAR_324 (Q[324] Q_B[324] VDD VSS VDD VSS) INVD0BWP16P90CPDLVT
BAR_325 (Q[325] Q_B[325] VDD VSS VDD VSS) INVD0BWP16P90CPDLVT
BAR_326 (Q[326] Q_B[326] VDD VSS VDD VSS) INVD0BWP16P90CPDLVT
BAR_327 (Q[327] Q_B[327] VDD VSS VDD VSS) INVD0BWP16P90CPDLVT
BAR_328 (Q[328] Q_B[328] VDD VSS VDD VSS) INVD0BWP16P90CPDLVT
BAR_329 (Q[329] Q_B[329] VDD VSS VDD VSS) INVD0BWP16P90CPDLVT
BAR_330 (Q[330] Q_B[330] VDD VSS VDD VSS) INVD0BWP16P90CPDLVT
BAR_331 (Q[331] Q_B[331] VDD VSS VDD VSS) INVD0BWP16P90CPDLVT
BAR_332 (Q[332] Q_B[332] VDD VSS VDD VSS) INVD0BWP16P90CPDLVT
BAR_333 (Q[333] Q_B[333] VDD VSS VDD VSS) INVD0BWP16P90CPDLVT
BAR_334 (Q[334] Q_B[334] VDD VSS VDD VSS) INVD0BWP16P90CPDLVT
BAR_335 (Q[335] Q_B[335] VDD VSS VDD VSS) INVD0BWP16P90CPDLVT
BAR_336 (Q[336] Q_B[336] VDD VSS VDD VSS) INVD0BWP16P90CPDLVT
BAR_337 (Q[337] Q_B[337] VDD VSS VDD VSS) INVD0BWP16P90CPDLVT
BAR_338 (Q[338] Q_B[338] VDD VSS VDD VSS) INVD0BWP16P90CPDLVT
BAR_339 (Q[339] Q_B[339] VDD VSS VDD VSS) INVD0BWP16P90CPDLVT
BAR_340 (Q[340] Q_B[340] VDD VSS VDD VSS) INVD0BWP16P90CPDLVT
BAR_341 (Q[341] Q_B[341] VDD VSS VDD VSS) INVD0BWP16P90CPDLVT
BAR_342 (Q[342] Q_B[342] VDD VSS VDD VSS) INVD0BWP16P90CPDLVT
BAR_343 (Q[343] Q_B[343] VDD VSS VDD VSS) INVD0BWP16P90CPDLVT
BAR_344 (Q[344] Q_B[344] VDD VSS VDD VSS) INVD0BWP16P90CPDLVT
BAR_345 (Q[345] Q_B[345] VDD VSS VDD VSS) INVD0BWP16P90CPDLVT
BAR_346 (Q[346] Q_B[346] VDD VSS VDD VSS) INVD0BWP16P90CPDLVT
BAR_347 (Q[347] Q_B[347] VDD VSS VDD VSS) INVD0BWP16P90CPDLVT
BAR_348 (Q[348] Q_B[348] VDD VSS VDD VSS) INVD0BWP16P90CPDLVT
BAR_349 (Q[349] Q_B[349] VDD VSS VDD VSS) INVD0BWP16P90CPDLVT
BAR_350 (Q[350] Q_B[350] VDD VSS VDD VSS) INVD0BWP16P90CPDLVT
BAR_351 (Q[351] Q_B[351] VDD VSS VDD VSS) INVD0BWP16P90CPDLVT
BAR_352 (Q[352] Q_B[352] VDD VSS VDD VSS) INVD0BWP16P90CPDLVT
BAR_353 (Q[353] Q_B[353] VDD VSS VDD VSS) INVD0BWP16P90CPDLVT
BAR_354 (Q[354] Q_B[354] VDD VSS VDD VSS) INVD0BWP16P90CPDLVT
BAR_355 (Q[355] Q_B[355] VDD VSS VDD VSS) INVD0BWP16P90CPDLVT
BAR_356 (Q[356] Q_B[356] VDD VSS VDD VSS) INVD0BWP16P90CPDLVT
BAR_357 (Q[357] Q_B[357] VDD VSS VDD VSS) INVD0BWP16P90CPDLVT
BAR_358 (Q[358] Q_B[358] VDD VSS VDD VSS) INVD0BWP16P90CPDLVT
BAR_359 (Q[359] Q_B[359] VDD VSS VDD VSS) INVD0BWP16P90CPDLVT
I67 (CLK[0] Q[339] Q[340] Q[341] Q[342] Q[343] Q[344] Q[345] Q[346] Q[347] Q[348] Q[349] Q[350] Q[351] Q[352] Q[353] Q[354] Q[355] Q[356] Q[357] Q[358] Q[359] VDD VSS) Latched_Shift_Register_20
I66 (CLK[3] Q[279] Q[280] Q[281] Q[282] Q[283] Q[284] Q[285] Q[286] Q[287] Q[288] Q[289] Q[290] Q[291] Q[292] Q[293] Q[294] Q[295] Q[296] Q[297] Q[298] Q[299] VDD VSS) Latched_Shift_Register_20
I65 (CLK[9] Q[159] Q[160] Q[161] Q[162] Q[163] Q[164] Q[165] Q[166] Q[167] Q[168] Q[169] Q[170] Q[171] Q[172] Q[173] Q[174] Q[175] Q[176] Q[177] Q[178] Q[179] VDD VSS) Latched_Shift_Register_20
I64 (CLK[8] Q_179_Drive Q[180] Q[181] Q[182] Q[183] Q[184] Q[185] Q[186] Q[187] Q[188] Q[189] Q[190] Q[191] Q[192] Q[193] Q[194] Q[195] Q[196] Q[197] Q[198] Q[199] VDD VSS) Latched_Shift_Register_20
I63 (CLK[7] Q[199] Q[200] Q[201] Q[202] Q[203] Q[204] Q[205] Q[206] Q[207] Q[208] Q[209] Q[210] Q[211] Q[212] Q[213] Q[214] Q[215] Q[216] Q[217] Q[218] Q[219] VDD VSS) Latched_Shift_Register_20
I62 (CLK[6] Q[219] Q[220] Q[221] Q[222] Q[223] Q[224] Q[225] Q[226] Q[227] Q[228] Q[229] Q[230] Q[231] Q[232] Q[233] Q[234] Q[235] Q[236] Q[237] Q[238] Q[239] VDD VSS) Latched_Shift_Register_20
I61 (CLK[10] Q[139] Q[140] Q[141] Q[142] Q[143] Q[144] Q[145] Q[146] Q[147] Q[148] Q[149] Q[150] Q[151] Q[152] Q[153] Q[154] Q[155] Q[156] Q[157] Q[158] Q[159] VDD VSS) Latched_Shift_Register_20
I60 (CLK[1] Q[319] Q[320] Q[321] Q[322] Q[323] Q[324] Q[325] Q[326] Q[327] Q[328] Q[329] Q[330] Q[331] Q[332] Q[333] Q[334] Q[335] Q[336] Q[337] Q[338] Q[339] VDD VSS) Latched_Shift_Register_20
I59 (CLK[2] Q_299_Drive Q[300] Q[301] Q[302] Q[303] Q[304] Q[305] Q[306] Q[307] Q[308] Q[309] Q[310] Q[311] Q[312] Q[313] Q[314] Q[315] Q[316] Q[317] Q[318] Q[319] VDD VSS) Latched_Shift_Register_20
I58 (CLK[11] Q[119] Q[120] Q[121] Q[122] Q[123] Q[124] Q[125] Q[126] Q[127] Q[128] Q[129] Q[130] Q[131] Q[132] Q[133] Q[134] Q[135] Q[136] Q[137] Q[138] Q[139] VDD VSS) Latched_Shift_Register_20
I57 (CLK[4] Q[259] Q[260] Q[261] Q[262] Q[263] Q[264] Q[265] Q[266] Q[267] Q[268] Q[269] Q[270] Q[271] Q[272] Q[273] Q[274] Q[275] Q[276] Q[277] Q[278] Q[279] VDD VSS) Latched_Shift_Register_20
I56 (CLK[5] Q[239] Q[240] Q[241] Q[242] Q[243] Q[244] Q[245] Q[246] Q[247] Q[248] Q[249] Q[250] Q[251] Q[252] Q[253] Q[254] Q[255] Q[256] Q[257] Q[258] Q[259] VDD VSS) Latched_Shift_Register_20
I55 (CLK[12] Q[99] Q[100] Q[101] Q[102] Q[103] Q[104] Q[105] Q[106] Q[107] Q[108] Q[109] Q[110] Q[111] Q[112] Q[113] Q[114] Q[115] Q[116] Q[117] Q[118] Q[119] VDD VSS) Latched_Shift_Register_20
I54 (CLK[13] Q[79] Q[80] Q[81] Q[82] Q[83] Q[84] Q[85] Q[86] Q[87] Q[88] Q[89] Q[90] Q[91] Q[92] Q[93] Q[94] Q[95] Q[96] Q[97] Q[98] Q[99] VDD VSS) Latched_Shift_Register_20
I53 (CLK[14] Q_59_Drive Q[60] Q[61] Q[62] Q[63] Q[64] Q[65] Q[66] Q[67] Q[68] Q[69] Q[70] Q[71] Q[72] Q[73] Q[74] Q[75] Q[76] Q[77] Q[78] Q[79] VDD VSS) Latched_Shift_Register_20
I52 (CLK[15] Q[39] Q[40] Q[41] Q[42] Q[43] Q[44] Q[45] Q[46] Q[47] Q[48] Q[49] Q[50] Q[51] Q[52] Q[53] Q[54] Q[55] Q[56] Q[57] Q[58] Q[59] VDD VSS) Latched_Shift_Register_20
I51 (CLK[16] Q[19] Q[20] Q[21] Q[22] Q[23] Q[24] Q[25] Q[26] Q[27] Q[28] Q[29] Q[30] Q[31] Q[32] Q[33] Q[34] Q[35] Q[36] Q[37] Q[38] Q[39] VDD VSS) Latched_Shift_Register_20
I50 (CLK[17] SDATA Q[0] Q[1] Q[2] Q[3] Q[4] Q[5] Q[6] Q[7] Q[8] Q[9] Q[10] Q[11] Q[12] Q[13] Q[14] Q[15] Q[16] Q[17] Q[18] Q[19] VDD VSS) Latched_Shift_Register_20
I70 (Q[299] Q_299_Drive VDD VSS VDD VSS) CKBD1BWP16P90CPDLVT
I69 (Q[179] Q_179_Drive VDD VSS VDD VSS) CKBD1BWP16P90CPDLVT
I68 (Q[59] Q_59_Drive VDD VSS VDD VSS) CKBD1BWP16P90CPDLVT
I47 (CLK[14] CLK[15] VDD VSS VDD VSS) CKBD1BWP16P90CPDLVT
I46 (CLK[12] CLK[13] VDD VSS VDD VSS) CKBD1BWP16P90CPDLVT
I45 (CLK[11] CLK[12] VDD VSS VDD VSS) CKBD1BWP16P90CPDLVT
I44 (CLK[13] CLK[14] VDD VSS VDD VSS) CKBD1BWP16P90CPDLVT
I43 (CLK[10] CLK[11] VDD VSS VDD VSS) CKBD1BWP16P90CPDLVT
I42 (CLK[8] CLK[9] VDD VSS VDD VSS) CKBD1BWP16P90CPDLVT
I41 (CLK[7] CLK[8] VDD VSS VDD VSS) CKBD1BWP16P90CPDLVT
I40 (CLK[9] CLK[10] VDD VSS VDD VSS) CKBD1BWP16P90CPDLVT
I39 (CLK[6] CLK[7] VDD VSS VDD VSS) CKBD1BWP16P90CPDLVT
I38 (CLK[4] CLK[5] VDD VSS VDD VSS) CKBD1BWP16P90CPDLVT
I37 (CLK[3] CLK[4] VDD VSS VDD VSS) CKBD1BWP16P90CPDLVT
I36 (CLK[5] CLK[6] VDD VSS VDD VSS) CKBD1BWP16P90CPDLVT
I35 (CLK[2] CLK[3] VDD VSS VDD VSS) CKBD1BWP16P90CPDLVT
I34 (CLK[0] CLK[1] VDD VSS VDD VSS) CKBD1BWP16P90CPDLVT
I33 (SCLK CLK[0] VDD VSS VDD VSS) CKBD1BWP16P90CPDLVT
I31 (CLK[1] CLK[2] VDD VSS VDD VSS) CKBD1BWP16P90CPDLVT
I48 (CLK[15] CLK[16] VDD VSS VDD VSS) CKBD1BWP16P90CPDLVT
I49 (CLK[16] CLK[17] VDD VSS VDD VSS) CKBD1BWP16P90CPDLVT
